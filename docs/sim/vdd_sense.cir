* Target VDD sense on A0 (PA0, ADC_IN0): divider R1/R2 with filter capacitor C1.
*
* Checks two things the firmware relies on:
*  1. After the target supply switches on, the sense node settles inside the 5 ms the
*     firmware waits (T_SETTLE_US in src/target_power.c).
*  2. The ADC's 5 pF sample-and-hold capacitor (CADC, DS12232 Table 58) sharing charge
*     with C1 during a conversion barely disturbs the reading. The worst case is an
*     empty CADC, connected for the sampling time of 160.5 cycles at 32 MHz (about 5 us,
*     src/adc.c), here at t = 6 ms.
*
* The supply is modelled as a step to 3.3 V through 0.1 ohm at t = 0; a real load switch
* ramps up more slowly, which only delays the start of the curve.
VSUP sup 0 PWL(0 0 1u 3.3)
RSW  sup vdd 0.1
R1   vdd sense 10k
R2   sense 0 10k
C1   sense 0 100n
* Sample-and-hold: an empty 5 pF capacitor switched onto the node for 5 us.
CADC hold 0 5p IC=0
SS   sense hold ctl 0 sample
VCTL ctl 0 PWL(0 0 6m 0 6.0001m 1 6.005m 1 6.0051m 0)
.model sample SW(Ron=1k Roff=1T Vt=0.5 Vh=0.1)
.tran 1u 8m uic
.control
run
meas tran v_final FIND v(sense) AT=5.99m
meas tran t_01pct WHEN v(sense)=1.6483 RISE=1
meas tran v_held FIND v(hold) AT=6.005m
let err_pct = 100 * (v_final - v_held) / v_final
print v_final t_01pct v_held err_pct
.endc
.end
